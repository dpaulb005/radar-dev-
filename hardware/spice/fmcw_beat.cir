* BLOCK 6 -- the radar itself, scaled so SPICE can run it.
* Real: 2440->2480 MHz (B=40 MHz) in T=6.4 ms, target 10 m (tau=66.7 ns) -> f_b = B*tau/T = 417 Hz
* Scaled x1/10 in bandwidth and x10 in delay: B=4 MHz (1->5 MHz), tau=667 ns  -> same 417 Hz
* Leakage: internal path 0.3 m -> tau 2 ns real -> 20 ns scaled -> 12.5 Hz, and 40 dB stronger.
.param T=6.4m
.param F0=1meg
.param B=4meg
* three consecutive chirps: t' = time mod T  (retrace ignored in the model)
B1    tx    0   V = cos(2*pi*(F0*(time-T*floor(time/T)) + 0.5*(B/T)*(time-T*floor(time/T))*(time-T*floor(time/T))))
* echo path: ideal delay line, then -40 dB
T1    tx 0  rxd 0  Z0=50 TD=667n
RT1   rxd 0 50
E1    echo 0 rxd 0 0.01
* leakage path: 20 ns, -0 dB relative to unity (i.e. 40 dB above the echo)
T2    tx 0  lkd 0  Z0=50 TD=20n
RT2   lkd 0 50
E2    leak 0 lkd 0 1.0
* mixer = multiplier
B2    ifm   0   V = V(tx)*(V(echo)+V(leak))
* 15.9 kHz low-pass (R12/C9) to leave only the beat, then the two 159 Hz
* high-passes of the video amp (C1/R2, C2/R6) which is what kills the leakage tone
R12   ifm  ifl 1k
C9    ifl  0   10n
C1    ifl  hp1 100n
R2    hp1  0   10k
C2    hp1  hp2 100n
R6    hp2  0   10k
.control
set wr_singlescale
set wr_vecnames
tran 10n 19.2m 0 10n
wrdata beat_tran.txt v(ifl) v(hp2)
quit
.endc
.end

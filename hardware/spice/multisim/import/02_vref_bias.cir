* VREF BIAS -- buffered half rail. VANA carries 100 mVpk of 150 kHz buck ripple.
* Expect: v(vref) = 5.58 V (generic op-amp) / 5.70 V (TL072CP), ripple < 1 uV.
.subckt TL072X inp inn vcc vee out
Rin   inp inn 1e12
E1    n1  0   inp inn 1e5
R1    n1  n2  1k
C1    n2  0   5.305u
E2    n3  0   n2  0   1
Rout  n3  out 100
Vch   vcc chp DC 1.5
Dch   out chp DCLAMP
Vcl   chn vee DC 1.5
Dcl   chn out DCLAMP
.model DCLAMP D(IS=1e-12 N=0.05)
.ends
VANA  vana 0  DC 11.4 AC 1 SIN(11.4 0.1 150k)
R9    vana vdiv 10k
R10   vdiv 0    10k
C5    vdiv 0    10u
XU2A  vdiv vbuf vana 0 vbuf TL072X
R11   vbuf vref 47
C6    vref 0    47u
C7    vana 0    100n
RL    vref 0    2.2k
.op
.ac dec 20 1 1meg
.tran 200n 200u 100u
.print ac vdb(vref)
.print tran v(vref) v(vana)
.end

* IF INPUT -- mixer IF port into 49.9 R + 1 nF, then the first 159 Hz high-pass.
* Expect: -6 dB at 417 Hz at the amp input, -58 dB at 2.44 GHz at the IF node.
VIF   vs 0  DC 0 AC 1
RS    vs if 50
R1    if 0  49.9
C20   if 0  1n
C1    if ap 100n
R2    ap 0  10k
.ac dec 10 10 10g
.print ac vdb(if) vdb(ap)
.end

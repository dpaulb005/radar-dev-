* BLOCK 1 -- video amplifier (U1A gain 101|22, U1B gain 11|1, 15.9 kHz LP, buffer)
* Multisim: TL072CP x2 (U1 A/B, U2 B), VANA = DC 11.4 V, VREF = DC 5.7 V (or the bias block)
.include tl072_macro.lib
.param RGAINA=1k          ; R4: 1k -> gain 101, 4.7k -> gain 22
.param RFB_B=10k          ; R7: 10k -> gain 11, 0.001 -> unity (JP2 closed)
.param VIN_AMP=10m        ; source amplitude (peak) for the transient test
.param VIN_F=1k
VANA  vana 0  DC 11.4
VREF  vref 0  DC 5.7
* mixer IF source: 50 ohm Thevenin
VIN   vs   0  DC 0 SIN(0 {VIN_AMP} {VIN_F}) AC 1
RS    vs   if 50
R1    if   0   49.9
C20   if   0   1n
C1    if   ap  100n
R2    ap   vref 10k
XU1A  ap   am  vana 0 aout TL072X
R3    aout am  100k
R4    am   vref {RGAINA}
C2    aout bp  100n
R6    bp   vref 10k
XU1B  bp   bm  vana 0 bout TL072X
R7    bout bm  {RFB_B}
R8    bm   vref 1k
R12   bout lp  1k
C9    lp   vref 10n
XU2B  lp   obuf vana 0 obuf TL072X
R13   obuf oiso 100
C10   oiso audio 10u
R14   audio 0  100k
RLOAD audio 0  10k          ; sound-card line input
.control
set wr_singlescale
set wr_vecnames
* AC response
ac dec 40 1 100k
wrdata ac_out.txt vdb(audio) vp(audio)
* transient at the requested level
tran 5u 60m 40m
wrdata tran_out.txt v(audio) v(aout) v(bout)
quit
.endc
.end

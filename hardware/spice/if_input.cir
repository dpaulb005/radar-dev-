* BLOCK 5 -- mixer IF port into 49.9 R + 1 nF: passes 417 Hz, kills 2.44 GHz LO leakage
VIF   vs 0  DC 0 AC 1
RS    vs if 50
R1    if 0  49.9
C20   if 0  1n
C1    if ap 100n
R2    ap 0  10k
.control
set wr_singlescale
set wr_vecnames
ac dec 10 10 10g
wrdata if_ac.txt vdb(if) vdb(ap)
print vdb(if) > /dev/null
quit
.endc
.end
